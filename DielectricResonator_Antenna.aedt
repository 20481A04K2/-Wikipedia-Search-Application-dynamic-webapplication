# Ansys Electronics Desktop project, version 2023.2
materials:
  vacuum: permittivity=1
  dra_diel: permittivity=9.5
  air: permittivity=1.0006 permeability=1.0000004

design HFSSDesign1 (HFSS, HFSS Hybrid Modal Network, model units mm)
options: Save_Adaptive_support_files
geometry:
  cavity [air] = sphere(centre=(0mm, 0mm, 0mm), radius=25mm)
  cavity.split(plane=XY, keep=NegativeOnly)
  DielectricResonator [dra_diel] = sphere(centre=(0mm, 0mm, 0mm), radius=12.5mm)
  DielectricResonator.split(plane=XY, keep=PositiveOnly)
  Circle1 = circle(normal=Z, centre=(0mm, 0mm, 0mm), radius=4.8mm)
  annular_rng = circle(normal=Z, centre=(0mm, 0mm, 0mm), radius=5.8mm)
  annular_rng.subtract(Circle1)
  annular_rng_Split1 = annular_rng.split(plane=YZ, keep=Both)
  annular_rng.move_edges(MoveAlongNormalFlag=true OffsetDistance=-0.25mm EdgesToMove=annular_rng.edge(#219))
  annular_rng_Split1.move_edges(MoveAlongNormalFlag=true OffsetDistance=-0.25mm EdgesToMove=annular_rng.edge(1 of 4))
  annular_rng.unite(annular_rng_Split1)
  p1, annular_rng_ObjectFromEdge2 = object_from(annular_rng.edge(#219, 1 of 4))
  p1.connect(annular_rng_ObjectFromEdge2)
  AirVol [air] = object_from(cavity.face(at (0, 0, 0)))
  AirVol.move_edges(MoveAlongNormalFlag=true OffsetDistance=5mm EdgesToMove=AirVol.edge(1 of 1))
  AirVol.thicken(20mm)
  GND [air] = object_from(AirVol.face(at (0, 0, 0)))
boundaries and excitations:
  GND: Perfect E Objects=GND
  AnnularRing: Perfect H Faces=annular_rng.face(at (0, -0.00269522, 0))
  Rad1: Radiation Faces=AirVol.face(at (30, 0, 10), at (0, 0, 20))
  1: Lumped Port Objects=p1 LumpedPortType=Modal Modes{Mode1{IntLine{(0, 5.7946096, 0) -> (0, 4.7934852, 0)} CharImp=Zpi RenormImp=50ohm}} Impedance=50ohm
mesh:
  initial mesh: GlobalSurfApproximation{CurvedSurfaceApproxChoice=UseSlider SliderMeshSettings=7} GlobalCurvilinear{Apply}
setups:
  3500MHz: HfssDriven Frequency=3500MHz MaxDeltaS=0.01 MaximumPasses=99 MinimumPasses=1 MinimumConvergedPasses=2 PercentRefinement=30 BasisOrder=-1 PortAccuracy=2 DrivenSolverType="Auto Select Direct/Iterative" IESolverType=ACA
    sweep 2500_4500MHz_D: 2.5GHz to 4.5GHz, 5 points; Type=Discrete SaveFields
    sweep 2500_4500MHz_I: 2.5GHz to 4.5GHz, 513 points; Type=Interpolating InterpTolerance=0.5 InterpMaxSolns=250 InterpUsePortImped=false PassivityErrorTolerance=0.0001
    sweep 2500_4500MHz_F: 2.5GHz to 4.5GHz, 513 points; Type=Fast SaveFields
source amplitudes:
  1:1: 1W 0deg
radiation setups:
  Infinite Sphere1: Infinite Sphere Theta=0deg..180deg step 1deg Phi=-180deg..180deg step 1deg
field plots:
  Mag_E1: E Field over GND.face on 3500MHz : LastAdaptive at Freq=3.5GHz Phase=0deg
  Mag_H1: H Field over annular_rng.face(at (0, -0.00269522, 0)) on 3500MHz : LastAdaptive at Freq=3.5GHz Phase=0deg
  Mag_E2, Mag_E3: E Field over a plane on 3500MHz : LastAdaptive at Freq=3.5GHz Phase=0deg
reports:
  S Parameter Plot 1: dB(S(1,1)) vs Freq on 3500MHz : 2500_4500MHz_I; markers m1 at 3.505859375GHz
  Z Parameter Plot 1: re(Z(1,1)), im(Z(1,1)) vs Freq on 3500MHz : 2500_4500MHz_I
  Gain Plot 1: dB(GainTotal) vs Phi, Theta on 3500MHz : LastAdaptive, Infinite Sphere1 [Freq=3.5GHz]
  Gain Plot 2: dB(GainTotal) vs Phi, Theta on 3500MHz : LastAdaptive, Infinite Sphere1 [Freq=3.5GHz]
